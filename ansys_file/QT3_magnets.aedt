# Ansys Electronics Desktop project, version 2023.2
materials:
  vacuum: permittivity=1

design qt3_2DMOT_sim (Maxwell 3D, Magnetostatic, model units mm)
geometry:
  Cylinder1 [vacuum] = cylinder(axis=Z, base_centre=(0mm, 0mm, 0mm), radius=0.22733mm, height=100mm)
mesh:
  initial mesh: GlobalCurvilinear{Apply}
